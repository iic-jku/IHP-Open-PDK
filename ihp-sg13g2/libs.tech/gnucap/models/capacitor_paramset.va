//******************************************************************************
//                                                                             *
// Copyright 2023 IHP PDK Authors                                              *
//                                                                             *
// Licensed under the Apache License, Version 2.0 (the "License");             *
// you may not use this file except in compliance with the License.            *
// You may obtain a copy of the License at                                     *
//                                                                             *
//     https://www.apache.org/licenses/LICENSE-2.0                             *
//                                                                             *
// Unless required by applicable law or agreed to in writing, software         *
// distributed under the License is distributed on an "AS IS" BASIS,           *
// WITHOUT WARRANTIES OR CONDITIONS OF ANY KIND, either express or implied.    *
// See the License for the specific language governing permissions and         *
// limitations under the License.                                              *
//                                                                             *
//******************************************************************************

// Verilog-A capacitors paramsets
// Ported from `ngspice/models/capacitors_*.lib` files
// Modifications:
// - remove sf scale factor from cmim_core
// - converted cjsw to SI units
// - corner parameters are resolved by cross-referencing corner modules
// (c) Lukas Deutz 2026

`pragma modelgen nogen-module
`include "capacitor.va"

//******************************************************************************
// parasitics
//******************************************************************************

// SiO2: only area cap., prozess tol. cap_cpara
// C value is taken from extraction routine

paramset cparasitic sp_capacitor
    parameter real c = 0.0;
    parameter real w = 0.0;
    parameter real l = 0.0;
    parameter real tc1 = 0.0;
    parameter real tc2 = 0.0;
    .capacitance = c * corner_cap.cap_cpara;
    .w = w;
    .l = l;
    .tc1 = tc1;
    .tc2 = tc2;
endparamset

//******************************************************************************
// cmim_core paramset
//******************************************************************************

// cmim_core paramset
// without mismatch (mm_ok = 0)
paramset cmim_core sp_capacitor
    parameter real l = 7.0u;
    parameter real w = 7.0u;
    parameter integer mm_ok = 0 from [0:0];
    .l = l;
    .w = w;
    .scale = 1;
    .tnom = 27.0;
    .tc1 = 3.6E-6;
    .tc2 = 2E-9;
    .cj = corner_cap.cap_carea;
    .cjsw = 40E-12; // F/m
endparamset

// with mismatch (mm_ok = 1)
paramset cmim_core sp_capacitor
    parameter real l = 7.0u;
    parameter real w = 7.0u;
    parameter integer mm_ok = 1 from [1:1];
    localparam real area_um = sqrt(l * w * 1e12);
    .l = l;
    .w = w;
    .scale = (1 + (cap_mm.cap_carea_mm - 1) / area_um);
    .tnom = 27.0;
    .tc1 = 3.6E-6;
    .tc2 = 2E-9;
    .cj = corner_cap.cap_carea;
    .cjsw = 40E-12; // F/m
endparamset
